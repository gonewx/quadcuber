* DSN-derived TI TPS54302 Steady_State reference testbench
* Locally reconstructed from original DSN by official KiCad parser;
* not an export made by Cadence. See pin-connectivity.csv and recovery-audit.json.
* Original model file is included read-only without modifications.
.INCLUDE "/workspace/tool-verification/ti-model/TPS54302_PSPICE_TRANS/TPS54302_TRANS.LIB"
.INCLUDE "../ti-name-alias.lib"
* DSN instance 16782995: C2; template: C^@REFDES %1 %2 ?TOLERANCE|C^@REFDES| @VALUE ?IC/IC=@IC/ ?TOLERANCE|\n.model C^@REFDES CAP C=1 DEV=@TOLERANCE%|
C_C2 VIN 0 10u
* DSN instance 16783013: C4; template: C^@REFDES %1 %2 ?TOLERANCE|C^@REFDES| @VALUE ?IC/IC=@IC/ ?TOLERANCE|\n.model C^@REFDES CAP C=1 DEV=@TOLERANCE%|
C_C4 BOOT SW 0.1u IC=12
* DSN instance 16782929: R5; template: R^@REFDES %1 %2 ?TOLERANCE|R^@REFDES| @VALUE  ?TOLERANCE|\n.model R^@REFDES RES R=1 DEV=@TOLERANCE%|
R_R5 0 EN 105k
* DSN instance 16777949: U1; template: X^@REFDES %BOOT %EN %GND %SW %VIN %FB @MODEL PARAMS: ?STEADY_STATE|STEADY_STATE=@STEADY_STATE||STEADY_STATE=0|
X_U1 BOOT EN 0 SW VIN VFB TPS54302DDC_TRANS PARAMS: STEADY_STATE=1
* DSN instance 16783033: C8; template: C^@REFDES %1 %2 ?TOLERANCE|C^@REFDES| @VALUE ?IC/IC=@IC/ ?TOLERANCE|\n.model C^@REFDES CAP C=1 DEV=@TOLERANCE%|
C_C8 N16785508 VFB 75p
* DSN instance 16782982: L1; template: X^@REFDES %1 %2 @MODEL PARAMS: ?L|L=@L||L=10U| ?DCR|DCR=@DCR||DCR=20M| ?IC|IC=@IC||IC=0|
X_L1 SW VOUT LDCR PARAMS: L=10u DCR=10m IC=3
* DSN instance 16782951: C1; template: C^@REFDES %1 %2 ?TOLERANCE|C^@REFDES| @VALUE ?IC/IC=@IC/ ?TOLERANCE|\n.model C^@REFDES CAP C=1 DEV=@TOLERANCE%|
C_C1 VIN 0 0.1u
* DSN instance 16783070: C5; template: X^@REFDES %1 %2 @MODEL PARAMS: ?C|C=@C||C=10U| ?ESR|ESR=@ESR||ESR=2M| ?IC|IC=@IC||IC=0| ?X|X=@X||X=0|
X_C5 VOUT 0 CESR PARAMS: C=22u ESR=2m IC=5 X=1
* DSN instance 16783003: Iload; template: I^@REFDES %+ %- ?DC|DC @DC| ?AC|AC @AC| ?TRAN|@TRAN|
I_Iload VOUT 0 DC 3
* DSN instance 16782970: Vin; template: V^@REFDES %+ %- @DC
V_Vin VIN 0 DC 12
* DSN instance 16783022: R1; template: R^@REFDES %1 %2 ?TOLERANCE|R^@REFDES| @VALUE  ?TOLERANCE|\n.model R^@REFDES RES R=1 DEV=@TOLERANCE%|
R_R1 N16785508 VOUT 49.9
* DSN instance 16783057: R3; template: R^@REFDES %1 %2 ?TOLERANCE|R^@REFDES| @VALUE  ?TOLERANCE|\n.model R^@REFDES RES R=1 DEV=@TOLERANCE%|
R_R3 0 VFB 13.3k
* DSN instance 16784060: IC1; template: .IC V(%+ )=@Value
.IC V(VOUT)=5
* DSN instance 16782940: R4; template: R^@REFDES %1 %2 ?TOLERANCE|R^@REFDES| @VALUE  ?TOLERANCE|\n.model R^@REFDES RES R=1 DEV=@TOLERANCE%|
R_R4 EN VIN 510k
* DSN instance 16783043: C6; template: X^@REFDES %1 %2 @MODEL PARAMS: ?C|C=@C||C=10U| ?ESR|ESR=@ESR||ESR=2M| ?IC|IC=@IC||IC=0| ?X|X=@X||X=0|
X_C6 VOUT 0 CESR PARAMS: C=22u ESR=2m IC=5 X=1
* DSN instance 16782959: R2; template: R^@REFDES %1 %2 ?TOLERANCE|R^@REFDES| @VALUE  ?TOLERANCE|\n.model R^@REFDES RES R=1 DEV=@TOLERANCE%|
R_R2 VFB N16785508 100k
* Analysis restored from original trans.sim; no UIC requested.
.OPTIONS ABSTOL=10n VNTOL=10u ITL1=1500 ITL2=400 ITL4=100
.TRAN 0 800u 750u 20n
.PROBE
.END
