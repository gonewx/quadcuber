ic_alias_space: original TI formal pin names, renamed actual nets, nonzero parameter value
VBIAS BIAS 0 1
X1 ACTUAL_EN ACTUAL_COMP TESTIC PARAMS: STEADY_STATE=1
.SUBCKT TESTIC EN COMP PARAMS: STEADY_STATE=0
RE BIAS EN 1k
CE EN 0 1u
RC COMP 0 1k
CC COMP 0 1u
.IC V(EN )=0
.IC V(COMP)={STEADY_STATE*1.3695}
.ENDS TESTIC
.GLOBAL BIAS
.TRAN 1u 1m 0 1u UIC
.PRINT TRAN FORMAT=CSV V(ACTUAL_EN) V(ACTUAL_COMP)
.END
