Nested subcircuit zero source IC A
VS IN 0 1
XTEST IN A B OUT RCIC
.SUBCKT RCIC IN A B OUT
R1 IN A 1k
C1 A 0 1u
VZERO A B 0Vdc
EOBS OUT 0 VALUE={V(B)**2}
.IC V(A)=0.25
.ENDS RCIC
.TRAN 1u 1m 0 1u
.PRINT TRAN FORMAT=CSV V(A) V(B) V(OUT) I(XTEST:VZERO)
.END
