Original TI U3 oscillator, unloaded SYSCLK, explicit SDWN=ULQ_MODE=0
.INCLUDE "/workspace/tool-verification/xyce-reference/TPS54302_TRANS.xyce-init.LIB"
VBOUND_SDWN SDWN 0 0
VBOUND_ULQ ULQ_MODE 0 0
X_U3_U137         U3_CLK_500K U3_ULQ_CLK ULQ_MODE SYSCLK MUX2_BASIC_GEN PARAMS:
+  VDD=1 VSS=0 VTHRESH=0.5
D_U3_D11         RAMP U3_N16804971 D_D2
V_U3_V45         U3_N16804971 0 5
V_U3_V47         U3_ULQ_CLK 0
+PULSE 0 1 0 1n 1n 12.5u 25u
C_U3_C1         0 U3_BLANK  1.443n
V_U3_VRAMP_MAX         U3_N16692390 0 1.75
X_U3_U135         U3_CLK_500K U3_N16810628 BUF_DELAY_BASIC_GEN PARAMS: VDD=1
+  VSS=0 VTHRESH=0.5 DELAY=20n
X_U3_U131         RAMP U3_N16692390 U3_CLK_500K COMP_BASIC_GEN PARAMS: VDD=1
+  VSS=0 VTHRESH=0.5
D_U3_D12         U3_N16817384 U3_BLANK D_D2
V_U3_V46         U3_N16813790 0
+PULSE 0.3u -0.3u 0 0.000512 0.000512 1n 0.001024002
X_U3_S26    U3_N16807586 0 RAMP 0 Oscillator_U3_S26
E_U3_E1         U3_N16817384 0 ULQ_MODE 0 1
G_U3_ABMII1         U3_N16804971 RAMP VALUE { V(U3_N16813790) + 5u    }
X_U3_U136         SDWN U3_BLANK U3_N16810628 U3_N16807586 OR3_BASIC_GEN PARAMS:
+  VDD=1 VSS=0 VTHRESH=500E-3
C_U3_CRAMP         RAMP 0  7.14286p
R_U3_R1         U3_N16817384 U3_BLANK  1k
.OPTIONS TIMEINT RELTOL=1e-5 ABSTOL=1e-9
.OPTIONS NONLIN-TRAN RELTOL=1e-6 ABSTOL=1e-12
.TRAN 20n 100u 0 20n
.PRINT TRAN FORMAT=CSV V(SYSCLK) V(RAMP) V(U3_CLK_500K) V(U3_N16810628) V(U3_N16807586) V(U3_BLANK) V(U3_N16813790)
.END
